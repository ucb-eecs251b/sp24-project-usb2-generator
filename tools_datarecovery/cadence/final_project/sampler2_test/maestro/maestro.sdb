ADE simulation setup
Run mode: Single Run, Sweeps and Corners
Tests:
  final_project_sampler2_test_1: final_project/sampler2_test/config, simulator spectre
    Variables: Fclk = 50M; Fin = 50M
    Outputs: D; Q; CLK
