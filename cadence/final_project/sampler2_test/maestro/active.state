ADE simulation setup
Test final_project_sampler2_test_1: final_project/sampler2_test/config, simulator spectre
  Models: /home/ff/eecs251b/sky130/sky130_cds/sky130_release_0.0.3/libs/sky130_fd_pr_main/../../models/sky130.lib.spice[tt]
  Variables: Fclk = 50M; Fin = 50M
  Temperature: 27
  Analysis dc: (saves the operating point)
  Analysis tran: stop=100n errpreset=conservative
  Output D = vtime("tran" "/D")
  Output Q = vtime("tran" "/Q")
  Output CLK = vtime("tran" "/CLK")
